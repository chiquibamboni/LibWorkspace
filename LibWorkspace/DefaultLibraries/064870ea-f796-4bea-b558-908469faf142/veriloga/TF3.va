nature sparameter
  access = S;
endnature

discipline sparameters
  flow sparameter;
enddiscipline

module TF3(p1,p2,p3,p4,p5,p6) (*model_type="distributed" port_type="four_pole"*);  //  port_type: "one_pole" or "two_pole"

inout      p1,p2,p3,p4,p5,p6;
sparameters p1,p2,p3,p4,p5,p6;
// Параметры компонентов

parameter real T1 = 1.41;
parameter real T2 = 1.41;

analog function real calcPropagation;
        input frequency;
        real frequency;
        begin
            real alpha;

            alpha = 0;

        end
    endfunction // calcPropagation

analog begin

    begin : initializeInstance
    end // initializeInstance

    calcPropagation($freq);

    real denom = 1 + T1*T1 + T2*T2;

    complex s11 = T1 * T1 / denom;
    complex s66 = T1 * T1 / denom;
    complex s44 = T2 * T2 / denom;
    complex s55 = T2 * T2 / denom;
    complex s22 = 1 / denom;
    complex s33 = 1 / denom;
    complex s16 = 1 - (T1 * T1 / denom);
    complex s61 = 1 - (T1 * T1 / denom);
    complex s45 = 1 - (T2 * T2 / denom);;
    complex s54 = 1 - (T2 * T2 / denom);
    complex s23 = 1 - (1 / denom);
    complex s32 = 1 - (1 / denom);

    complex s12 = T1 / denom;
    complex s21 = T1 / denom;
    complex s13 = -T1 / denom;
    complex s31 = -T1 / denom;
    complex s26 = -T1 / denom;
    complex s62 = -T1 / denom;
    complex s36 = T1 / denom;
    complex s63 = T1 / denom;

    complex s24 = -T2 / denom;
    complex s42 = -T2 / denom;
    complex s25 = T2 / denom;
    complex s52 = T2 / denom;
    complex s34 = T2 / denom;
    complex s43 = T2 / denom;
    complex s35 = -T2 / denom;
    complex s53 = -T2 / denom;

    complex s14 = -T1 * T2 / denom;
    complex s41 = -T1 * T2 / denom;
    complex s15 = T1 * T2 / denom;
    complex s51 = T1 * T2 / denom;
    complex s46 = T1 * T2 / denom;
    complex s64 = T1 * T2 / denom;
    complex s56 = -T1 * T2 / denom;
    complex s65 = -T1 * T2 / denom;

    S(p1,p1) <+ s11;
    S(p1,p2) <+ s12;
    S(p1,p3) <+ s13;
    S(p1,p4) <+ s14;
    S(p1,p5) <+ s15;
    S(p1,p6) <+ s16;

    S(p2,p1) <+ s21;
    S(p2,p2) <+ s22;
    S(p2,p3) <+ s23;
    S(p2,p4) <+ s24;
    S(p2,p5) <+ s25;
    S(p2,p6) <+ s26;

    S(p3,p1) <+ s31;
    S(p3,p2) <+ s32;
    S(p3,p3) <+ s33;
    S(p3,p4) <+ s34;
    S(p3,p5) <+ s35;
    S(p3,p6) <+ s36;

    S(p4,p1) <+ s41;
    S(p4,p2) <+ s42;
    S(p4,p3) <+ s43;
    S(p4,p4) <+ s44;
    S(p4,p5) <+ s45;
    S(p4,p6) <+ s46;

    S(p5,p1) <+ s51;
    S(p5,p2) <+ s52;
    S(p5,p3) <+ s53;
    S(p5,p4) <+ s54;
    S(p5,p5) <+ s55;
    S(p5,p6) <+ s56;

    S(p6,p1) <+ s61;
    S(p6,p2) <+ s62;
    S(p6,p3) <+ s63;
    S(p6,p4) <+ s64;
    S(p6,p5) <+ s65;
    S(p6,p6) <+ s66;

end // analog

endmodule
