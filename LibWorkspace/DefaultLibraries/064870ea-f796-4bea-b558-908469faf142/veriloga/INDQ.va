`include "constants.h"
`include "disciplines.h"

module INDQ (p1, p2);
    inout p1, p2;
    electrical p1, p2, n1;

    // Параметры компонентов

    parameter real L = 1n;
    parameter real Q = 50;
    parameter real F = 1e9;

  real R;

    analog begin

//mode = proportional to freq

       R = 2 * `M_PI * F * L / Q;

       V(p1, n1) <+ R * (I(p1, n1));
       V(n1, p2) <+ L * ddt(I(n1, p2));

  end
endmodule
