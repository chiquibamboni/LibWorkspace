`include "constants.h"
`include "disciplines.h"
`define e0          8.8541878e-12
module TFR(p, n);
    inout p, n;
    electrical p, n;

(*desc="W", type="instance"*)                     parameter real W = 20u from (0.0:inf);
(*desc="L", type="instance"*)                      parameter real L = 20u from (0.0:inf);
(*desc="Rsheet", type="instance"*)              parameter real Rsheet = 50 from (0.0:inf);
(*desc="substrate permittivity relative to a vacuum", type="instance"*)                      parameter real er = 9.8 from (0.0:inf);
(*desc="substrate height",        unit="m"            type="instance"*)                      parameter real h = 0.1m from (0.0:inf);
(*desc="substrate",                                   type="instance", resolve_type="text"*) parameter string subst = "";
    // Параметры компонентов

    real R1;
    real Ls;
    real Cp1;
    real Cp2;
    real Cpph;
    real w;
    real l;
    real H;

// Параметры компонентов

     real C1 = 0.1e-15;

    // Внутренние узлы
    electrical node1;

    analog begin

         Cpph = er * `e0 * W * L / (0.7 * h);

         w = W * 1e6; // перевод в м
         l = L * 1e6;    // перевод в м
         H = h * 1e6;
         R1 = (L / W) * Rsheet;

         real ff = $freq/1e9;
         Ls =abs((1e-12)*((3.2998e-01)*er-(1.2951e-02)*H-(6.6153e-01)*w-(5.6583e-02)*l-(2.7060e-02)*Rsheet-(2.3064e-02)*er*er-(1.1295e-02)*er*H-(9.4516e-02)*er*w+(9.3815e-03)*er*l+(1.0551e-02)*er*Rsheet+(6.1787e-04)*H*H+(1.7216e-03)*H*w-(3.6265e-04)*H*l-(2.8773e-04)*H*Rsheet+(2.2770e-02)*w*w-(6.4722e-03)*w*l-(4.0882e-03)*w*Rsheet+(4.0883e-04)*l*l-(1.0774e-04)*l*Rsheet+(2.6026e-04)*Rsheet*Rsheet+(8.4633e-04)*er*er*er+(1.6760e-04)*er*er*H+(1.0142e-03)*er*er*w-(3.4684e-04)*er*er*l-(1.8792e-04)*er*er*Rsheet+(5.1451e-05)*er*H*H+(9.9385e-05)*er*H*w-(6.5588e-05)*er*H*l-(3.3365e-05)*er*H*Rsheet+(8.4623e-04)*er*w*w-(5.1603e-04)*er*w*l-(2.6028e-04)*er*w*Rsheet+(1.2675e-04)*er*l*l+(1.2236e-04)*er*l*Rsheet+(1.8850e-05)*er*Rsheet*Rsheet-(2.9594e-06)*H*H*H-(5.5040e-06)*H*H*w+(3.6582e-06)*H*H*l+(1.8554e-06)*H*H*Rsheet-(1.1683e-05)*H*w*w+(8.0939e-06)*H*w*l+(4.0548e-06)*H*w*Rsheet-(2.3881e-06)*H*l*l-(2.3387e-06)*H*l*Rsheet-(3.5686e-07)*H*Rsheet*Rsheet-(1.3448e-04)*w*w*w+(8.8293e-05)*w*w*l+(4.4773e-05)*w*w*Rsheet-(2.3663e-05)*w*l*l-(2.5323e-05)*w*l*Rsheet-(4.0144e-06)*w*Rsheet*Rsheet+(1.8509e-06)*l*l*l+(5.6449e-06)*l*l*Rsheet+(2.0288e-06)*l*Rsheet*Rsheet-(9.2884e-08)*Rsheet*Rsheet*Rsheet-(1.1246e-05)*er*er*er*er-(1.4973e-06)*er*er*er*H-(7.1239e-06)*er*er*er*w+(5.4458e-06)*er*er*er*l+(2.4143e-06)*er*er*er*Rsheet-(1.9312e-07)*er*er*H*H-(5.0360e-07)*er*er*H*w+(3.6211e-07)*er*er*H*l+(1.5862e-07)*er*er*H*Rsheet-(2.8362e-06)*er*er*w*w+(2.4622e-06)*er*er*w*l+(1.0851e-06)*er*er*w*Rsheet-(8.6244e-07)*er*er*l*l-(7.4890e-07)*er*er*l*Rsheet-(1.1171e-07)*er*er*Rsheet*Rsheet-(6.5810e-08)*er*H*H*H-(9.3095e-08)*er*H*H*w+(1.0080e-07)*er*H*H*l+(4.6205e-08)*er*H*H*Rsheet-(1.6622e-07)*er*H*w*w+(1.6000e-07)*er*H*w*l+(7.3838e-08)*er*H*w*Rsheet-(6.0507e-08)*er*H*l*l-(7.3957e-08)*er*H*l*Rsheet-(6.7924e-09)*er*H*Rsheet*Rsheet-(1.4797e-06)*er*w*w*w+(1.3089e-06)*er*w*w*l+(5.9681e-07)*er*w*w*Rsheet-(3.9395e-07)*er*w*l*l-(4.9315e-07)*er*w*l*Rsheet-(3.8826e-08)*er*w*Rsheet*Rsheet-(2.2512e-09)*er*l*l*l+(1.2962e-07)*er*l*l*Rsheet+(2.8387e-08)*er*l*Rsheet*Rsheet-(4.3390e-09)*er*Rsheet*Rsheet*Rsheet+(3.6749e-09)*H*H*H*H+(5.5935e-09)*H*H*H*w-(5.8363e-09)*H*H*H*l-(2.6588e-09)*H*H*H*Rsheet+(9.0536e-09)*H*H*w*w-(8.9954e-09)*H*H*w*l-(4.1080e-09)*H*H*w*Rsheet+(3.7090e-09)*H*H*l*l+(4.1642e-09)*H*H*l*Rsheet+(4.4042e-10)*H*H*Rsheet*Rsheet+(1.7704e-08)*H*w*w*w-(1.6882e-08)*H*w*w*l-(7.7104e-09)*H*w*w*Rsheet+(5.9175e-09)*H*w*l*l+(7.2918e-09)*H*w*l*Rsheet+(6.1026e-10)*H*w*Rsheet*Rsheet-(3.1699e-10)*H*l*l*l-(2.7028e-09)*H*l*l*Rsheet-(6.6763e-10)*H*l*Rsheet*Rsheet+(5.9295e-11)*H*Rsheet*Rsheet*Rsheet+(1.9589e-07)*w*w*w*w-(1.7594e-07)*w*w*w*l-(8.3278e-08)*w*w*w*Rsheet+(5.6884e-08)*w*w*l*l+(7.1236e-08)*w*w*l*Rsheet+(7.4779e-09)*w*w*Rsheet*Rsheet-(9.3223e-10)*w*l*l*l-(2.1159e-08)*w*l*l*Rsheet-(5.6952e-09)*w*l*Rsheet*Rsheet+(5.8423e-10)*w*Rsheet*Rsheet*Rsheet-(1.3583e-09)*l*l*l*l+(3.5024e-10)*l*l*l*Rsheet+(1.1328e-09)*l*l*Rsheet*Rsheet-(3.9937e-10)*l*Rsheet*Rsheet*Rsheet+(1.2370e-11)*Rsheet*Rsheet*Rsheet*Rsheet+3.7121e+00));

         Cp1 = (1e-15)*abs(-(2.4330e-01)*er+(3.2885e-02)*H-(4.6717e-03)*w-(4.7167e-03)*l-(5.2047e-04)*Rsheet+(3.4356e-05)*er*er-(1.4209e-02)*er*H+(9.6644e-03)*er*w+(1.2174e-02)*er*l+(1.4332e-05)*er*Rsheet+(7.8222e-04)*H*H-(5.7402e-04)*H*w-(6.2013e-04)*H*l-(2.3157e-06)*H*Rsheet-(8.4857e-05)*w*w+(4.3356e-04)*w*l-(1.4618e-08)*w*Rsheet-(1.1214e-05)*l*l-(5.4938e-06)*l*Rsheet+(2.3002e-07)*Rsheet*Rsheet+(3.7883e-05)*er*er*er+(5.0844e-06)*er*er*H+(8.0708e-06)*er*er*w+(2.7007e-05)*er*er*l+(2.9365e-06)*er*er*Rsheet+(1.1585e-04)*er*H*H-(8.6503e-05)*er*H*w-(9.2911e-05)*er*H*l-(2.4870e-07)*er*H*Rsheet-(6.5817e-06)*er*w*w+(6.6747e-05)*er*w*l+(5.1626e-07)*er*w*Rsheet+(2.8577e-06)*er*l*l+(1.6240e-06)*er*l*Rsheet-(7.5190e-09)*er*Rsheet*Rsheet-(6.0430e-06)*H*H*H+(4.9038e-06)*H*H*w+(5.0784e-06)*H*H*l-(5.8591e-09)*H*H*Rsheet-(4.1471e-08)*H*w*w-(3.7393e-06)*H*w*l-(8.7190e-09)*H*w*Rsheet-(8.0966e-08)*H*l*l-(4.3392e-08)*H*l*Rsheet+(1.4098e-09)*H*Rsheet*Rsheet+(4.2391e-07)*w*w*w-(3.0997e-07)*w*w*l-(1.8252e-08)*w*w*Rsheet+(2.7434e-08)*w*l*l+(1.9340e-08)*w*l*Rsheet+(2.0605e-09)*w*Rsheet*Rsheet+(3.5912e-08)*l*l*l+(4.4472e-08)*l*l*Rsheet);

         //Cp1 = (1e-15)*((1.5673e-2)*w+(2.5915e-2)*l-(3.2918e-3)*Rsheet-(1.0687e-4)*w*w+(6.6583e-4)*w*l+(9.7234e-6)*w*Rsheet+(7.8781e-5)*l*l+(3.0032e-5)*l*Rsheet+(5.1891e-7)*Rsheet*Rsheet+(1.6188e-7)*w*w*w-(1.4434e-7)*w*w*l-(1.3714e-8)*w*w*Rsheet-(6.6215e-9)*w*l*l-(1.5914e-9)*w*l*Rsheet-(1.1548e-9)*w*Rsheet*Rsheet-(8.7011e-8)*l*l*l-(6.5283e-8)*l*l*Rsheet-(5.7368e-9)*l*Rsheet*Rsheet+(1.7680e-10)*Rsheet*Rsheet*Rsheet+9.1324e-01);
         Cp2=Cp1;

        // Последовательная цепь: R -> L (между p и node1)
        V(p, node1) <+ R1 * I(p, node1);
        V(node1, n) <+ abs(Ls) * ddt(I(node1, n));

        // Параллельный путь: C между p и n
        I(p, n) <+ C1 * ddt(V(p, n));

        I(p) <+ Cp1 * ddt(V(p));
        I(p) <+ Cpph * ddt(V(p));

        I(n) <+ Cp2 * ddt(V(n));
        I(n) <+ Cpph * ddt(V(n));

    end
endmodule
