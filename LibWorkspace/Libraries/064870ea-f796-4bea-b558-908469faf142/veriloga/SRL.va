`include "constants.h"
`include "disciplines.h"

module SRL (p1, p2);
    inout p1, p2;
    electrical p1, p2, n1;

    // Параметры компонентов
    parameter real R = 1;
    parameter real L = 1n;

    analog begin

       V(p1, n1) <+ L * ddt(I(p1, n1));
       V(n1, p2) <+ R * (I(n1, p2));

  end
endmodule
