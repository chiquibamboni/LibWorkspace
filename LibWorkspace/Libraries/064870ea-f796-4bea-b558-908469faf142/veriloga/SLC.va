`include "constants.h"
`include "disciplines.h"

module SLC (p1, p2);
    inout p1, p2;
    electrical p1, p2, n1;

    // Параметры компонентов
    parameter real L = 1n;
    parameter real C = 1p;

    analog begin

       V(p1, n1) <+ L * ddt(I(p1,n1));
       I(n1, p2) <+ C * ddt(V(n1, p2));

  end
endmodule
