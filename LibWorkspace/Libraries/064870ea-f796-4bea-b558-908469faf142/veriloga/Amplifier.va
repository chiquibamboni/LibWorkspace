nature sparameter
  access = S;
endnature

discipline sparameters
  flow sparameter;
enddiscipline

`define z0          50.0

`define C0          299792458.0
`define MU0         12.566370614e-7
`define Z0          376.73031346958504364963

`define pi          3.1415926535897932384626433832795029
`define pi_over_2   1.5707963267948966192313216916397514
`define one_over_pi 0.3183098861837906715377675267450287
`define two_over_pi 0.6366197723675813430755350534900574
`define euler       2.7182818284590452353602874713526625
`define ln2         0.6931471805599453094172321214581766

// IMPORTANT WARNING
// In c, c++, spectre, hspice natural logarithm - "log", and in VerilogA - "ln";
// In c, c++, spectre, hspice decimal logarithm - "log10", and in VerilogA - "log";

module Amplifier(p1,p2) (*model_type="distributed"  port_type="one_pole"*);  //  port_type: "one_pole" or "two_pole"

inout      p1,p2;
sparameters p1,p2;

(*type="instance", unit="dB"*) parameter real G = 25 from (0.0:inf);
(*type="instance", unit="Ohm"*) parameter real Z1 = 50 from (0.0:inf);
(*type="instance", unit="Ohm"*) parameter real Z2 = 50 from (0.0:inf);
(*type="instance", unit="dB"*) parameter real s11 = -13;
(*type="instance", unit="dB"*) parameter real s22 = -15;

analog begin
    real VSWR1 = (1 + pow(10, -abs(s11) / 20)) / (1 - pow(10, -abs(s11)/20));
    real VSWR2 = (1 + pow(10, -abs(s22) / 20)) / (1 - pow(10, -abs(s22)/20));

    complex S11 = (VSWR1 - 1) / (VSWR1 + 1);
    complex S21 = 4 * `z0 * sqrt(Z1 * Z2) * (pow(10, abs(G)/20)) / ((Z1 + `z0) * (Z2 + `z0));
    complex S22 = (VSWR2 - 1) / (VSWR2 + 1);

    S(p1,p1) <+ S11;
    S(p1,p2) <+ 0;
    S(p2,p1) <+ S21;
    S(p2,p2) <+ S22;

end // analog

endmodule
