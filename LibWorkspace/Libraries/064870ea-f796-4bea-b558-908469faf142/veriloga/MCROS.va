`include "constants.h"
`include "disciplines.h"

`define pi          3.1415926535897932384626433832795029

module MCROS (p1, p2, p3, p4);
  inout p1, p2, p3, p4;
  electrical p1, p2, p3, p4;

 (*desc="width13",                   unit="u",           type="instance"*) parameter real W13    = 25u;    // Ширина проводника (в мкм)
 (*desc="width24",                   unit="u",           type="instance"*) parameter real W24    = 25u;    // Ширина проводника (в мкм)

  (*desc="substrate permittivity relative to a vacuum", type="instance"*)                      parameter real er = 9.6 from (0.0:inf);
                                                                                             aliasparam eps = er;
  (*desc="substrate height",        unit="m"            type="instance"*)                      parameter real h = 10u from (0.0:inf);
  (*desc="conductor thickness",     unit="m"            type="instance"*)                      parameter real t = 35u from (0.0:inf);
  (*desc="loss tangent",                                type="instance"*)                      parameter real tand = 2e-4 from (0.0:inf);
  (*desc="metal resistivity",                           type="instance"*)                      parameter real rho = 0.022e-6 from (0.0:inf);
  (*desc="surface roughness (RMS)",                     type="instance"*)                      parameter real d = 0.15e-6 from (0.0:inf);

  (*desc="substrate",                                   type="instance", resolve_type="text"*) parameter string subst = "";

  real X;
  real Y;
  real ltotal1;
  real ltotal2;
  real ltotal5;
  real cval;

  electrical node1;
  electrical node2;

 analog begin

     X=ln(W13/h)*(86.6*(W24/h)-30.9*sqrt(W24/h)+367)+pow((W24/h),3)+74*(W24/h)+130;

     cval=0.25*W13*(X*(pow(((h/W13)),(1/3)))-240+(2*h/W24)-1.5*(W13/h)*(1-(W24/h)));

     Y=165.6*(W24/h)+31.2*(sqrt(W24/h))-11.8*(pow((W24/h),2));

     ltotal1=h*(Y*(W13/h)-32*W24/h+3)*(pow((h/W13),1.5));

     ltotal2=h*(Y*(W24/h)-32*W13/h+3)*(pow((h/W24),1.5));

     ltotal5=h*(5*W24/h*cos(`pi/2*(1.5-(W13/h))-(1+(7*h/W13))*(h/W24))-337.5);

    V(p1, node1) <+ ltotal1*(1e-9) * ddt(I(p1, node1));
    V(node1, p3) <+ ltotal1*(1e-9) * ddt(I(node1, p3));
    V(node1, node2) <+ ltotal5*(1e-9) * ddt(I(node1, node2));
    V(p2, node2) <+ ltotal2*(1e-9) * ddt(I(p2, node2));
    V(node2, p4) <+ ltotal2*(1e-9) * ddt(I(node2, p4));

    I(p1) <+ cval*(1e-12) * ddt(V(p1));
    I(p2) <+ cval*(1e-12) * ddt(V(p2));
    I(p3) <+ cval*(1e-12) * ddt(V(p3));
    I(p4) <+ cval*(1e-12) * ddt(V(p4));

  end
endmodule
