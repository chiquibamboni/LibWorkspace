nature sparameter
  access = S;
endnature

discipline sparameters
  flow sparameter;
enddiscipline

module Switch(p1, p2, p3)
  (*model_type="distributed" port_type="one_pole"*);

inout p1, p2, p3;
sparameters p1, p2, p3;

// Комплексные параметры S (объявляем один раз)
complex s11, s12, s13, s21, s22, s23, s31, s32, s33;

(*desc="state", type="instance"*)
parameter real state = 0.0 from [0.0:1.0];

analog begin
    if (state != 1.0) begin
         s11 = 0.1e-44;
         s12 = 1.0;
         s13 = 0.1e-44;
         s21 = 1.0;
         s22 = 0.1e-44;
         s23 = 0.1e-44;
         s31 = 0.1e-44;
         s32 = 0.1e-44;
         s33 = 1.0;
    end else begin
         s11 = 0.1e-44;
         s12 = 0.1e-44;
         s13 = 1.0;
         s21 = 0.1e-44;
         s22 = 1.0;
         s23 = 0.1e-44;
         s31 = 1.0;
         s32 = 0.1e-44;
         s33 = 0.1e-44;
    end

    // Присваивание S-параметров
    S(p1,p1) <+ s11;
    S(p1,p2) <+ s12;
    S(p1,p3) <+ s13;
    S(p2,p1) <+ s21;
    S(p2,p2) <+ s22;
    S(p2,p3) <+ s23;
    S(p3,p1) <+ s31;
    S(p3,p2) <+ s32;
    S(p3,p3) <+ s33;
end

endmodule
