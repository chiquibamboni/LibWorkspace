nature sparameter
  access = S;
endnature

discipline sparameters
  flow sparameter;
enddiscipline

`define  z0         50.0

`define C0          299792458.0
`define MU0         12.566370614e-7
`define Z0          376.73031346958504364963

`define pi          3.1415926535897932384626433832795029
`define pi_over_2   1.5707963267948966192313216916397514
`define one_over_pi 0.3183098861837906715377675267450287
`define two_over_pi 0.6366197723675813430755350534900574
`define euler       2.7182818284590452353602874713526625
`define ln2         0.6931471805599453094172321214581766

// IMPORTANT WARNING
// In c, c++, spectre, hspice natural logarithm - "log", and in VerilogA - "ln";
// In c, c++, spectre, hspice decimal logarithm - "log10", and in VerilogA - "log";

module MVIA(p1,p2) (*model_type="distributed" port_type="one_pole"*);  //  port_type: "one_pole" or "two_pole"

inout      p1,p2;
sparameters p1,p2;

(*desc="width",                   unit="m",           type="instance"*)                      parameter real w = 25u from (0.0:inf);
(*desc="Hole diameter",                  unit="m",           type="instance"*)                      parameter real D = 15u from (0.0:inf);
//(*desc="dispersion model",                            type="instance", resolve_type="text"*) parameter string dispmodel = "Hammerstad";
//(*desc="model",                                       type="instance", resolve_type="text"*) parameter string model = "Wheeler";

//(*desc="substrate permittivity relative to a vacuum", type="instance"*)                      parameter real er = 9.8 from (0.0:inf);
                                                                                             //aliasparam eps = er;
(*desc="substrate height",        unit="m"            type="instance"*)                      parameter real h = 0.1m from (0.0:inf);
(*desc="conductor thickness",     unit="m"            type="instance"*)                      parameter real t = 3u from (0.0:inf);
//(*desc="loss tangent",                                type="instance"*)                      parameter real tand = 2e-4 from (0.0:inf);
(*desc="metal resistivity",                           type="instance"*)                      parameter real rho = 2.2e-8 from (0.0:inf);
//(*desc="surface roughness (RMS)",                     type="instance"*)                      parameter real d = 0.15e-6 from (0.0:inf);

(*desc="substrate",                                   type="instance", resolve_type="text"*) parameter string subst = "";

    analog function real sqr;
        input r;
        real r;
        sqr = r*r;
    endfunction

       real fs, R, rr, v, res, a, ind;

    analog function real calcPropagation;
        input frequency;
        real frequency;
        begin
// расчет основных параметров

         fs = `pi * `MU0 * t * t / rho;
         rr = D / 2;
         v = (sqr(rr) - sqr(rr - t)) * h / `pi;
         R = rho * v;
         res = R * sqrt(1 + frequency * fs);
         a = sqrt(sqr(rr) + sqr(h));
         ind = frequency * `MU0 * (h * ln((h + a) / rr) + 1.5 * (rr - a));

        end
    endfunction // calcPropagation

analog begin

    begin : initializeInstance
    end // initializeInstance

    calcPropagation($freq);

    complex Z = $complex(res, ind);
    complex z  = Z / `z0;

    complex s11 = z / (z + $complex(2.0, 0.0));
    complex s21 = $complex(2.0, 0.0) / (z + $complex(2.0, 0.0));

    S(p1,p1) <+ s11;
    S(p1,p2) <+ s21;
    S(p2,p1) <+ s21;
    S(p2,p2) <+ s11;

end // analog

endmodule
