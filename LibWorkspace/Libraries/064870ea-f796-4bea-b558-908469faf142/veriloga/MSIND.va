`include "constants.h"
`include "disciplines.h"

module MSIND(p, n);
    inout p, n;
    electrical p, n;

(*desc="N", type="instance"*)                     parameter real N = 2 from (0.0:inf);
(*desc="ri", type="instance"*)                     parameter real ri = 50u from (0.0:inf);
(*desc="W", type="instance"*)                      parameter real W = 10u from (0.0:inf);
(*desc="S", type="instance"*)                      parameter real S = 10u from (0.0:inf);

(*desc="substrate permittivity relative to a vacuum", type="instance"*)                      parameter real er = 9.8 from (0.0:inf);
(*desc="substrate height",        unit="m"            type="instance"*)                      parameter real h = 0.1m from (0.0:inf);
(*desc="substrate",                                   type="instance", resolve_type="text"*) parameter string subst = "";
    // Параметры компонентов

    real Ri;
    real Rs;
    real Ls;
    real Cp1;
    real Cp2;

// Параметры компонентов
    // Внутренние узлы
    electrical node1;

    analog begin

         Ri = ri * 1e6;

         Rs = abs(-(7.6858e-03)*N-(1.7342e-04)*Ri+(7.4103e-02)*N*N+(7.3512e-03)*N*Ri+(7.1725e-07)*Ri*Ri-(7.0970e-05)*N*N*N-(6.7020e-06)*N*N*Ri-(1.6064e-07)*N*Ri*Ri-(8.1048e-10)*Ri*Ri*Ri+1.1468e-02);

         Ls =abs(-(8.1740e-01)*N-(1.2841e-02)*Ri+(1.9659e-01)*N*N+(1.0348e-02)*N*Ri+(3.9534e-05)*Ri*Ri+(6.4484e-04)*N*N*N+(1.0795e-03)*N*N*Ri+(1.8487e-07)*N*Ri*Ri-(1.1188e-07)*Ri*Ri*Ri+9.2454e-01);

         Cp1 = abs((1.5604e+00)*N+(1.1695e-01)*Ri+(4.6259e-01)*N*N+(6.7868e-02)*N*Ri+(1.6141e-05)*Ri*Ri+(1.0458e-02)*N*N*N-(1.3455e-04)*N*N*Ri+(9.5106e-06)*N*Ri*Ri-(1.0760e-07)*Ri*Ri*Ri+9.2454e-01);

         Cp2 = abs((7.8067e-01)*N+(1.1447e-01)*Ri+(9.3788e-01)*N*N+(7.2441e-02)*N*Ri-(1.9470e-05)*Ri*Ri-(1.0136e-02)*N*N*N+(1.6551e-04)*N*N*Ri-(8.7506e-06)*N*Ri*Ri+(1.1140e-07)*Ri*Ri*Ri+9.2454e-01);

        V(p, node1) <+ (Ls * (1e-9)) * ddt(I(p, node1));
        V(node1, n) <+ Rs * I(node1, n);

        I(p) <+ (Cp1 * 1e-15) * ddt(V(p));
        I(n) <+ (Cp2 * 1e-15) * ddt(V(n));

    end
endmodule
