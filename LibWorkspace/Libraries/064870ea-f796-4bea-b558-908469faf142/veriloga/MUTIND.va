`include "constants.h"
`include "disciplines.h"

module MUTIND (p1, p2, p3, p4);
    inout p1, p2, p3, p4;
    electrical p1, p2, p3, p4;

    // Параметры компонентов
    parameter real L1 = 1n;
    parameter real L2 = 1n;
    parameter real k = 0.5;

    real m12;

    analog begin

     m12 = k * sqrt(L1 * L2);

     V(p1, p2) <+ L1 * ddt(I(p1, p2)) + m12 * ddt(I(p3, p4));
     V(p3, p4) <+ L2 * ddt(I(p3, p4)) + m12 * ddt(I(p1, p2));

  end
endmodule
